ADE simulation setup
Run mode: Single Run, Sweeps and Corners
Tests:
  cs2s-rf_mos_tb_1: cs2s-rf/mos_tb/schematic, simulator spectre
    Variables: vdd = 0.4; vgs = 0.9; vds = 0.8
