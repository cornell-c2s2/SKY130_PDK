ADE simulation setup
Test cs2s-rf_mos_tb_1: cs2s-rf/mos_tb/schematic, simulator spectre
  Models: /home/jtw88/SKY130_PDK/sky130_release/libs/sky130_fd_pr_main/../../models/sky130.lib.spice[tt]
  Variables: vdd = 0.4; vgs = 0.9; vds = 0.8
  Temperature: 27
  Analysis tran: stop=5u errpreset=conservative
Run mode: Single Run, Sweeps and Corners
